** sch_path: /foss/designs/foldedOTA.sch
**.subckt foldedOTA VDD Vbp VOUT VinP VinN Vbn VSS
*.iopin VDD
*.iopin VSS
*.iopin VOUT
*.iopin Vbp
*.iopin Vbn
*.iopin VinN
*.iopin VinP
XM1 net2 VinP net1 VSS sg13_hv_nmos w=28u l=1u ng=4
XM2 net3 VinN net1 VSS sg13_hv_nmos w=28u l=1u ng=4
XM3 net1 net8 VSS VSS sg13_hv_nmos w=15u l=1u ng=3
XM4 net2 net7 VDD VDD sg13_hv_pmos w=14u l=1u ng=2
XM5 net3 net7 VDD VDD sg13_hv_pmos w=14u l=1u ng=2
XM6 net4 Vbp net2 VDD sg13_hv_pmos w=2u l=1u ng=1
XM7 VOUT Vbp net3 VDD sg13_hv_pmos w=2u l=1u ng=1
XM8 net4 Vbn net5 VSS sg13_hv_nmos w=7u l=1u ng=1
XM9 VOUT Vbn net6 VSS sg13_hv_nmos w=7u l=1u ng=1
XM10 net5 net4 VSS VSS sg13_hv_nmos w=7u l=1u ng=1
XM11 net6 net4 VSS VSS sg13_hv_nmos w=7u l=1u ng=1
XM12 net8 net8 VSS VSS sg13_hv_nmos w=15u l=1u ng=3
I0 VDD net8 50u
XM13 net7 net7 VDD VDD sg13_hv_pmos w=14u l=1u ng=2
I1 net7 0 50u
**.ends
.end
