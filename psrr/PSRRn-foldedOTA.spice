** sch_path: /foss/designs/PSRRn-foldedOTA.sch
**.subckt PSRRn-foldedOTA
VPac VinP GND 1.8
VNac VinN GND 1.8
Vbnmos Vbn GND 1.25
Vbpmos Vbp GND 0.5
VDD VDD GND 3.3
x1 VDD Vbp Vout VinP VinN Vbn VSS foldedOTA
C1 Vout GND 10p
VSSac VSS GND 0 ac 1
**** begin user architecture code

.lib cornerMOShv.lib mos_tt

.control
close all
destroy all

ac dec 20 1 200G
let gain_vss_db = db(Vout/v(VSS))
meas ac avss_dc_gain find gain_vss_db at=1

alter VPac ac = 100m
alter VNac ac = -100m
alter VSSac ac = 0
ac dec 20 1 200G
let VinDiff = v(VinP) - v(VinN)
let gain_dm_db = db(Vout/VinDiff)
meas ac adm_dc_gain find gain_dm_db at=1

let psrr_neg_dc = adm_dc_gain - ac1.avss_dc_gain
let psrr_neg_full = gain_dm_db - ac1.gain_vss_db

print adm_dc_gain
print ac1.avss_dc_gain
print psrr_neg_dc

plot ac1.gain_vss_db gain_dm_db
plot psrr_neg_full
.endc

**** end user architecture code
**.ends

* expanding   symbol:  foldedOTA.sym # of pins=7
** sym_path: /foss/designs/foldedOTA.sym
** sch_path: /foss/designs/foldedOTA.sch
.subckt foldedOTA VDD Vbp VOUT VinP VinN Vbn VSS
*.iopin VDD
*.iopin VSS
*.iopin VOUT
*.iopin Vbp
*.iopin Vbn
*.iopin VinN
*.iopin VinP
XM1 net2 VinP net1 VSS sg13_hv_nmos w=28u l=1u ng=4
XM2 net3 VinN net1 VSS sg13_hv_nmos w=28u l=1u ng=4
XM3 net1 net8 VSS VSS sg13_hv_nmos w=15u l=1u ng=3
XM4 net2 net7 VDD VDD sg13_hv_pmos w=14u l=1u ng=2
XM5 net3 net7 VDD VDD sg13_hv_pmos w=14u l=1u ng=2
XM6 net4 Vbp net2 VDD sg13_hv_pmos w=2u l=1u ng=1
XM7 VOUT Vbp net3 VDD sg13_hv_pmos w=2u l=1u ng=1
XM8 net4 Vbn net5 VSS sg13_hv_nmos w=7u l=1u ng=1
XM9 VOUT Vbn net6 VSS sg13_hv_nmos w=7u l=1u ng=1
XM10 net5 net4 VSS VSS sg13_hv_nmos w=7u l=1u ng=1
XM11 net6 net4 VSS VSS sg13_hv_nmos w=7u l=1u ng=1
XM12 net8 net8 VSS VSS sg13_hv_nmos w=15u l=1u ng=3
I0 VDD net8 50u
XM13 net7 net7 VDD VDD sg13_hv_pmos w=14u l=1u ng=2
I1 net7 VSS 50u
.ends

.GLOBAL GND
.end
